* ============================================================
* swr_bridge_spice.cir
* Tandem Match Directional Coupler — SPICE Simulation
* ============================================================
* 基于 John Grebenkemper, KI6WX QST Jan 1987 设计
* 适配: FT37-43 磁芯, 10T 次级, BAT41 检波
*
* 仿真目标:
*   1. 耦合度 (Coupling Factor) vs 频率: S31, S41
*   2. 方向性 (Directivity): S31 - S41 @ 50Ω load
*   3. 插入损耗 (Insertion Loss): S21
*   4. 检波器输出电压 vs 输入功率
*   5. BAT41 Vf 匹配误差对方向性的影响
*
* 运行: ngspice -b swr_bridge_spice.cir
*      或 LTSpice 打开此文件
* ============================================================

* ============================================================
* 1. 电路拓扑
* ============================================================
*
*    Port1 (RF IN)                           Port2 (RF OUT → Antenna)
*     50Ω ○─────┬─────────────────┬────────────○ 50Ω
*                │                 │
*                │    ┌────────────┼────┐
*                │    │  Tandem Match Coupler  │
*                │    │                        │
*                │    │  T1 (FWD): FT37-43     │
*                │    │  主线穿过磁环中心 (1T)  │
*                │    │  次级 10T #24 AWG      │
*                │    │                        │
*                │    │  T2 (REV): FT37-43     │
*                │    │  主线穿过磁环中心 (1T)  │
*                │    │  次级 10T #24 AWG (反) │
*                │    └───┬────────────────┬───┘
*                │        │                │
*                │   Port3 (FWD)      Port4 (REV)
*                │    50Ω Load          50Ω Load
*                │        │                │
*                │     BAT41             BAT41
*                │     (检波)            (检波)
*                │        │                │
*                │    ┌───┴────┐      ┌───┴────┐
*                │    │ 10nF    │      │ 10nF    │ 滤波
*                │    │ ===     │      │ ===     │
*                │    │  │      │      │  │      │
*                │    └───┼────┘      └───┼────┘
*                │        │                │
*                │    V_FWD_DC         V_REV_DC
*                │   (→ MCU AN0)      (→ MCU AN1)
*                │
*               GND

* ============================================================
* 2. 仿真参数
* ============================================================
.param F_LOW  = 1.8Meg
.param F_HIGH = 30Meg
.param F_STEP = 500k
.param P_IN   = 10    ; 输入功率 (W) for 谐波平衡/瞬态
.param Z0     = 50    ; 系统阻抗

* ============================================================
* 3. 元件模型
* ============================================================

*** 3.1 FT37-43 磁芯耦合电感模型 ***
* 主线: 穿过磁环中心 = 1 匝等效
* 次级: 10T
* 耦合系数 k ≈ 0.3 (单匝穿过环形磁芯的典型耦合度)
* AL = 420 nH/N²
* L_primary_1T = 420 nH (but this is the through-line, not a winding)
* L_secondary  = AL * N² = 420nH * 10² = 42 µH

* T1 (FWD coupler): 主线电感 + 次级电感 + 互感
L_fwd_pri  N001 N002  420n    ; 主线等效电感 (1T through core)
L_fwd_sec  N003 N004  42u     ; 次级 10T
K_fwd L_fwd_pri L_fwd_sec 0.3  ; 耦合系数

* T2 (REV coupler): 同 T1, 但次级反向连接
L_rev_pri  N002 N005  420n
L_rev_sec  N006 N007  42u
K_rev L_rev_pri L_rev_sec 0.3

* 磁芯损耗等效并联电阻 (FT37-43 @ 7MHz, Q≈50)
* R_parallel = Q * XL = 50 * 2π * 7MHz * 420nH ≈ 923Ω
R_fwd_loss N001 N002 1k
R_rev_loss N002 N005 1k

*** 3.2 BAT41 肖特基二极管模型 ***
* 基于 ST BAT41 数据手册
* IS=2.2E-7 N=1.08 RS=4.5 CJO=20p BV=100 IBV=10U
.MODEL BAT41 D (
+ IS   = 2.2E-7     ; 反向饱和电流
+ N    = 1.08        ; 理想因子
+ RS   = 4.5         ; 串联电阻 (Ω)
+ CJO  = 20p         ; 零偏结电容 (pF)
+ VJ   = 0.65        ; 结电势 (V)
+ M    = 0.5         ; 梯度因子
+ BV   = 100         ; 击穿电压 (V)
+ IBV  = 10U         ; 击穿电流 (A)
+ TT   = 5N          ; 渡越时间 (s)
+ EG   = 0.69        ; 能带隙 (eV)
+ XTI  = 2           ; 饱和电流指数
+ )

*** 3.3 精密 50Ω 终端电阻 ***
R_fwd_term  N003 N004 50
R_rev_term  N006 N007 50

*** 3.4 检波器负载 ***
* R_load = 1MΩ for Schottky (原设计推荐)
R_fwd_load  N008 0 1Meg
R_rev_load  N009 0 1Meg

*** 3.5 滤波电容 ***
C_fwd_filt  N008 0 10n
C_rev_filt  N009 0 10n

* ============================================================
* 4. 激励与负载
* ============================================================

*** 4.1 RF 输入源 ***
* SINE 模式 (CW): DC=0, AMPL=1, FREQ=14.1Meg
* AC 模式 (扫频): AC=1
V_rf_in   N001 0 DC(0) SINE(0 {sqrt(2*P_IN*Z0)} 14.1Meg) AC(1)
R_source  N001 N001_internal 50

*** 4.2 输出负载 (50Ω 天线) ***
R_load_out N005 0 50

*** 4.3 失配模拟 (可选: 100Ω = SWR 2.0) ***
* 取消注释下面这行来模拟 SWR 2.0:
* R_load_out N005 0 100

* ============================================================
* 5. 仿真实例
* ============================================================

*** 5.1 AC 小信号分析 (扫频): 耦合度 & 方向性 ***
* .ac dec 50 {F_LOW} {F_HIGH}
*
* 耦合度 (Coupling, dB):
*   S31 = V(N008) / V(N001)
*   S41 = V(N009) / V(N001)
*
* 方向性 (Directivity, dB):
*   D  = 20*log10(V(N008)/V(N009))  (when load = 50Ω)
*
* 插入损耗 (Insertion Loss, dB):
*   S21 = V(N005) / V(N001)

*** 5.2 瞬态分析 (时域): 检波器输出电压 ***
* .tran 1n 10u
* 观察 V(N008) 和 V(N009) 的 DC 分量

*** 5.3 蒙特卡洛 (BAT41 Vf 匹配误差) ***
* 修改 D2 的 IS 参数 ±5% 来模拟不匹配
* 观察方向性退化

* ============================================================
* 6. 预期结果 (台架校准参考值)
* ============================================================
*
* 频率    耦合度 S31   方向性    插入损耗 S21
* 1.8 MHz   ~-28 dB    >30 dB    <0.05 dB
* 7.1 MHz   ~-26 dB    >28 dB    <0.08 dB
* 14.2 MHz  ~-24 dB    >26 dB    <0.10 dB
* 21.2 MHz  ~-22 dB    >24 dB    <0.12 dB
* 28.5 MHz  ~-20 dB    >22 dB    <0.15 dB
*
* FWD 检波器输出 (50Ω load, CW):
*   5W  →  ~1.5-2.0V DC
*   50W →  ~3.0-3.5V DC
*   100W → ~3.5-4.5V DC (接近饱和)
*
* REV 检波器输出 (50Ω load):
*   < 10mV (完美匹配)
*   ~1.0V (SWR=2.0)

* ============================================================
* 7. 控制语句 (取消注释来运行)
* ============================================================
* .control
*   ac dec 50 1.8Meg 30Meg
*   plot db(v(n008)/v(n001)) db(v(n009)/v(n001))
*   plot db(v(n008)/v(n009))
*   plot db(v(n005)/v(n001))
* .endc

.end
