* ============================================================
* lc_resonant_tank.cir
* T200-2 并联 LC 谐振回路 — SPICE Simulation
* ============================================================
* 仿真 EFHW 调谐适配器的核心谐振回路。
* T200-2 ×2 双叠磁芯, 2:13 匝比自耦变压器。
* 7位二进制电容阵列 (10-1997 pF, 步进 ~10-15 pF)。
*
* 仿真目标:
*   1. 谐振频率 vs 电容值 (f_res = 1 / (2π√(LC)))
*   2. Q 值 (空载 Q_u & 有载 Q_loaded)
*   3. 阻抗变换验证 (42.25:1 = 50Ω → 2,112Ω)
*   4. 电容阵列峰值电压 vs 输入功率 (100W)
*   5. 3dB 带宽 (调谐匹配带宽)
*   6. 电容误差对 SWR 的影响 (5% 容差)
*
* 运行: ngspice -b lc_resonant_tank.cir
* ============================================================

* ============================================================
* 1. 电路拓扑
* ============================================================
*
*   Port1 (50Ω IN)                         Port2 (Antenna ~2,112Ω)
*       ○                                       ○
*       │                                       │
*   ┌───┴───┐                              ┌───┴───────────┐
*   │ 2T    │    T200-2 ×2 (双叠)         │ Counterpoise  │
*   │Pri.  │  ═══════════════════         │  2m Wire      │
*   │       │   耦合系数 k≈0.95           │  ≈2,112Ω      │
*   └───┬───┘                              └───┬───────────┘
*       │                                       │
*       │    ┌──────────────────────┐          │
*       │    │  C_array (10-1997pF) │          │
*       │    │  C1:10p  C5:220p    │          │
*       │    │  C2:22p  C6:470p    │          │
*       │    │  C3:47p  C7:1000p   │          │
*       │    │  C4:100p            │          │
*       │    └──────────┬───────────┘          │
*       │               │                      │
*       └───────────────┴──────────────────────┘
*                      GND

* ============================================================
* 2. 仿真参数
* ============================================================
.param F_START  = 5Meg       ; 起始频率
.param F_STOP   = 35Meg      ; 终止频率
.param F_CENTER = 14.1Meg    ; 目标谐振频率 (20m band)
.param P_IN     = 100        ; 输入功率 (W)
.param Z_IN     = 50         ; 输入阻抗
.param C_VAL    = 100p       ; 当前电容值 (扫描变量)

* ============================================================
* 3. T200-2 磁芯变压器模型
* ============================================================

*** 3.1 T200-2 ×2 双叠参数 ***
* AL = 12 nH/N² (单只), 双叠 ≈ 24 nH/N² (理想叠加)
* 实际双叠耦合 < 100%: AL_effective ≈ 20 nH/N²
.param AL_EFF = 20n

* 初级电感 (2T): L_pri = AL * N² = 20nH * 4 = 80 nH
* 次级电感 (13T): L_sec = AL * N² = 20nH * 169 = 3.38 µH
.param L_PRI = 80n
.param L_SEC = 3.38u

* 磁芯损耗等效并联电阻
* Q_u @ 7MHz ≈ 250 (Mix-2 粉末铁芯)
* Q_u @ 14MHz ≈ 200
* Q_u @ 28MHz ≈ 160
* R_parallel = Q_u × XL
* @ 14.1MHz: XL_sec = 2π × 14.1MHz × 3.38µH ≈ 299Ω
*            R_par = 200 × 299 ≈ 60kΩ
.param R_CORE_LOSS = 60k

* 耦合系数 (简单并绕, W8JI 验证)
.param K_COUPLING = 0.92

*** 3.2 变压器 SPICE 模型 ***
* 使用理想变压器 + 磁化电感 + 漏感的 T模型

* 磁化电感 (初级侧)
L_mag  N001 0  {L_PRI}

* 理想变压器 (匝数比 2:13)
* 使用受控源实现
E_sec N003 0 N001 0 {13/2}   ; V_sec = 6.5 × V_pri

* 漏感 (次级侧, 估算为总电感的 ~5%)
L_leak N003 N004 {L_SEC * 0.05}

* 磁芯损耗电阻
R_core N004 0 {R_CORE_LOSS}

* 次级自感 (扣除漏感)
L_sec_main N004 N005 {L_SEC * 0.95}

* ============================================================
* 4. 电容阵列模型
* ============================================================

*** 4.1 主调谐电容 (二进制权值) ***
* C_array 由 7 个继电器控制位组成:
* bit0=10pF, bit1=22pF, bit2=47pF, bit3=100pF
* bit4=220pF, bit5=470pF, bit6=1000pF
* 总范围: 0 (全部断开) ~ 1997pF (全部接入, 但 C_array 通常不设 0)

* 仿真时设置 c_val 来选择接入的电容
.param C_BIT0 = 10p     ; 10 pF ×1
.param C_BIT1 = 22p     ; 22 pF ×1
.param C_BIT2 = 47p     ; 47 pF ×1
.param C_BIT3 = 100p    ; 100 pF ×1
.param C_BIT4 = 220p    ; 220 pF ×1
.param C_BIT5 = 470p    ; 220pF || 250pF
.param C_BIT6 = 1000p   ; 470pF×2 || 56pF

* 当前电容值 (模拟 c_val 对应的实际接入电容)
* 例如 c_val=42 → bit1(22p)+bit3(100p)+bit5(470p)=592pF
.param C_TOTAL = {C_BIT0 + C_BIT1 + C_BIT3 + C_BIT5}  ; 示例: 592pF

*** 4.2 电容 SPICE 模型 (C0G/NPO, 1812) ***
* C0G 等效串联电阻 ESR 极低, 但需要包含
* ESR @ 14MHz (Q>1000): ESR = 1/(2πfCQ) ≈ 1/(2π×14MHz×100p×1000) ≈ 0.11Ω
* ESL (1812 封装): ~0.8nH
.param C_ESR = 0.15     ; 等效串联电阻 (Ω)
.param C_ESL = 0.8n     ; 等效串联电感 (H)

C_tune  N005 N006 {C_TOTAL}
R_esr   N006 N007 {C_ESR}
L_esl   N007 0    {C_ESL}

*** 4.3 PCB 杂散电容 (B区 HV_BUS 对地) ***
* 估算: 5mm 宽, 适当长度的铜轨对地平面
* C_stray ≈ ε₀ × ε_r × Area / distance
* ≈ 8.85e-12 × 4.5 × (0.005×0.05) / 0.0016 ≈ 6pF
C_stray N005 0 6p

* ============================================================
* 5. 源与负载
* ============================================================

*** 5.1 RF 输入 (50Ω 源) ***
V_rf_in  N_IN 0 DC(0) AC(1) SINE(0 {sqrt(2*P_IN*Z_IN)} {F_CENTER})
R_source N_IN  N001 50

*** 5.2 天线负载 (等效 ~2,112Ω 电阻性) ***
* EFHW 在谐振时为高阻抗纯电阻
R_ant N005 0 2112

* ============================================================
* 6. 仿真分析
* ============================================================

*** 6.1 AC 扫频: 谐振特性 ***
* 观测 N001 的输入阻抗 Z_in = V(N001)/I(V_rf_in) (反射到初级)
* 预期: 在谐振频率处 Z_in ≈ 50Ω (纯电阻, SWR ≈ 1.0)
*       谐振频率 = 1/(2π√(L_SEC_eff × C_TOTAL))
*       L_SEC_eff ≈ L_SEC × (1 - k²) + 折合到次级的磁化电感
*
* 对于 c_val=42 (C_TOTAL=592pF):
*   f_res = 1/(2π√(3.38µH × 592pF)) ≈ 3.56 MHz ← 偏低!
*   说明需要更小的电容来覆盖 14.1 MHz
*   14.1 MHz 需要的电容: C = 1/((2π×14.1MHz)² × 3.38µH) ≈ 37.5pF
*   这对应于 c_val ≈ 4-8 (只接入 10-100pF 级别的小电容)
*
*   这验证了为什么 7位 128档在 HF 高频段是足够的:
*   高频段用小电容 (高分辨率), 低频段用大电容。

*** 6.2 电容阵列谐振频率表 (理论计算) ***
* c_val   C_total (pF)   f_res @ L_sec=3.38µH  对应频段
* 0       10 + stray      27.4 MHz              10m
* 4       47 + stray      21.2 MHz              15m
* 8       110 + stray     15.7 MHz              17m
* 16      210 + stray     11.8 MHz              (WARC)
* 24      320 + stray      9.7 MHz              30m
* 40      600 + stray      7.1 MHz              40m
* 80      1200 + stray     5.0 MHz              (60m)
* 127     1997 + stray     3.9 MHz              (80m, 边际)

*** 6.3 峰值电压分析 (时域/谐波平衡) ***
* V_peak across C_tune = Q_loaded × V_source_secondary
* V_source_secondary = √(P × Z_ant) = √(100 × 2112) ≈ 460V RMS
* Q_loaded ≈ 12 (at 14.1 MHz)
* V_peak_cap = 12 × 460 × √2 ≈ 7,800V !!
*
* ⚠️ 这超过了 3KV MLCC 的额定值!
* 重新计算: Q_loaded 可能在有载时远低于空载 Q_u
* Q_loaded = R_load / X_L = 2112 / 299 ≈ 7.0 (@ 14.1 MHz)
* V_peak_cap ≈ 7.0 × 460 × √2 ≈ 4,560V
*
* 仍然超过 3KV! 但在实际中:
*   - Q_loaded 因天线自身的损耗而进一步降低 (~5)
*   - 大多数操作在 <100W 进行
*   - C0G 有短时过压容限 (2× rated for short pulses)
*
* 结论: 100W CW 连续发射时, 电容阵列工作在其额定极限附近。
*       建议在 100W 场景下使用 5KV 额定电容, 或将功率限制在 60W CW。

* ============================================================
* 7. 蒙特卡洛: 电容误差对 SWR 的影响
* ============================================================
* 每只电容 ±5% 容差 → 对谐振频率的影响:
* Δf/f ≈ -½ × ΔC/C ≈ ±2.5%
* @ 14.1 MHz → Δf ≈ ±350 kHz
* 对于 FT8 (3 kHz 带宽), 350 kHz 偏移意味着 SWR 显著恶化
* → 这验证了为什么需要 128 档 (1pF 步进) 的细粒度调谐

* ============================================================
* 8. 控制语句 (取消注释来运行)
* ============================================================
* .control
*   ac dec 100 5Meg 35Meg
*   * 输入阻抗 (反射到 50Ω 端口)
*   let Zin = v(n001) / i(V_rf_in)
*   let SWR = (1 + abs((Zin - 50)/(Zin + 50))) / (1 - abs((Zin - 50)/(Zin + 50)))
*   plot db(Zin) phase(Zin)
*   plot SWR
*
*   * 电容电压
*   plot db(v(n005))
*
*   * 扫描不同电容值
*   alterparam C_TOTAL = 10p
*   ac dec 100 5Meg 35Meg
*   alterparam C_TOTAL = 47p
*   ac dec 100 5Meg 35Meg
*   alterparam C_TOTAL = 110p
*   ac dec 100 5Meg 35Meg
* .endc

.end
