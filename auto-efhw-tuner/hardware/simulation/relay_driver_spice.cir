* ============================================================
* relay_driver_spice.cir
* ULN2003A + G5Q-14 继电器驱动电路 — SPICE Simulation
* ============================================================
* 仿真继电器线圈驱动电路, 重点关注:
*   1. 线圈吸合/释放瞬态 (电流上升/衰减时间)
*   2. 反峰电压 (ULN2003A COM 脚浮空 vs 正确连接)
*   3. 继电器触点动作时间 (机械延迟)
*   4. ULN2003A 达林顿管功耗 vs 开关频率
*   5. 多继电器同时吸合时的总电流冲击
*
* 运行: ngspice -b relay_driver_spice.cir
* ============================================================

* ============================================================
* 1. 电路拓扑
* ============================================================
*
*   +5V (MCU GPIO)
*        │
*    ┌───┴───┐
*    │ 10kΩ  │ 限流电阻 (可选)
*    └───┬───┘
*        │
*   ULN2003A 达林顿输入 (2.7kΩ 基极电阻内置)
*        │
*   ┌────┴────┐
*   │   COM   ├──────────── VCC_12V (+12V)
*   │   (Pin9)│              │
*   │         │         ┌────┴────┐
*   │         │         │ 续流二极管│ (ULN2003A 内置)
*   │         │         │ (COM → OUTx)│
*   │         │         └────┬────┘
*   │   OUTx  ├──────────────┤
*   │  (Pin10 │              │
*   │  -16)   │         ┌────┴────┐
*   └────┬────┘         │ 继电器线圈│
*        │              │ G5Q-14   │
*        │              │ 12VDC    │
*       GND             │ R_coil≈720Ω│
*                       │ L_coil≈0.5H│
*                       └────┬────┘
*                            │
*                           GND

* ============================================================
* 2. 仿真参数
* ============================================================
.param VCC_12V   = 12
.param V_MCU_HI  = 5.0
.param V_MCU_LO  = 0.0
.param T_ON      = 50m       ; 吸合持续 (ms)
.param T_OFF     = 50m       ; 释放持续 (ms)

* ============================================================
* 3. 元件模型
* ============================================================

*** 3.1 MCU GPIO 输出 (5V CMOS, 简化) ***
V_gpio  N_GPIO 0 DC(0) PULSE({V_MCU_LO} {V_MCU_HI} 10m 1u 1u {T_ON} {T_ON+T_OFF})

*** 3.2 ULN2003A 达林顿管 (简化模型) ***
* 达林顿 = 两个 NPN 级联
* hFE_total ≈ 1000 (典型)
* VCE(sat) ≈ 0.9V @ 100mA
* 内置 2.7kΩ 基极电阻
R_base   N_GPIO N_BASE 2.7k

* 第一级 NPN
Q1 N_COL1 N_BASE N_EMIT1 0 2N2222
* 第二级 NPN (达林顿对)
Q2 N_COIL N_COL1 N_EMIT1 0 2N2222

* 发射极到地 (通过电流检测电阻, 可选)
R_emit   N_EMIT1 0 0.1

* ULN2003A 内部续流二极管 (COM → OUTx)
* COM 必须接 +12V 才生效!
D_clamp N_COIL N_VCC12 1N4007

*** 3.3 2N2222 NPN 模型 ***
.MODEL 2N2222 NPN (
+ IS    = 3.3E-14
+ BF    = 200
+ NF    = 1.0
+ VAF   = 100
+ IKF   = 0.3
+ ISE   = 2.5E-13
+ NE    = 1.5
+ BR    = 6
+ NR    = 1.0
+ VAR   = 20
+ IKR   = 0.15
+ ISC   = 0
+ NC    = 2.0
+ RB    = 10
+ IRB   = 1E-6
+ RBM   = 5
+ RE    = 0.2
+ RC    = 0.5
+ CJE   = 27p
+ VJE   = 0.75
+ MJE   = 0.33
+ CJC   = 9p
+ VJC   = 0.65
+ MJC   = 0.33
+ TF    = 350p
+ TR    = 20n
+ )

*** 3.4 G5Q-14 继电器线圈 ***
* 线圈电阻: ~720 Ω (12V/16.7mA)
* 线圈电感: ~0.5 H (推定, 小型功率继电器典型值)
* 触点模型未在 SPICE 中建模 (机械部件)
R_coil   N_VCC12 N_COIL 720
L_coil   N_VCC12 N_COIL 0.5

*** 3.5 电源 ***
V_12V    N_VCC12 0 DC({VCC_12V})

*** 3.6 1N4007 二极管模型 (用于续流钳位) ***
.MODEL 1N4007 D (
+ IS    = 7.0E-9
+ N     = 1.85
+ RS    = 0.035
+ CJO   = 50p
+ VJ    = 0.6
+ M     = 0.33
+ BV    = 1000
+ IBV   = 10U
+ TT    = 5U
+ )

* ============================================================
* 4. 仿真分析
* ============================================================

*** 4.1 瞬态分析: 线圈电流 & 反峰电压 ***
* 观测:
*   I(L_coil) — 吸合/释放瞬态
*   V(N_COIL) — ULN2003A 集电极电压 (正常: ~0.9V sat)
*   V(N_COIL) — 释放时: 如果 COM 浮空 → 飞至 64V+
*               如果 COM 接 +12V → 钳位到 ~12.7V

*** 4.2 反峰电压定量分析 ***
* 释放瞬间, 线圈电流不能突变:
*   V_L = -L × di/dt
*   如果没有续流二极管: di/dt 由达林顿管击穿电压决定
*   V_peak ≈ V_CEO(Q2) ≈ 40-60V (2N2222)
*   对于 ULN2003A 内部达林顿: V_CEO ≈ 50V
*   → COM 浮空时 V_ce 可能超过 50V → 达林顿雪崩击穿
*
*   有续流二极管 (COM 接 +12V):
*   线圈电流通过 D_clamp 续流
*   V_coil ≈ VCC_12V + Vf_diode ≈ 12.7V
*   电流衰减时间 = L/R ≈ 0.5H / 720Ω ≈ 0.7ms
*
*   继电器释放时间 (触点弹开): 典型 ~5ms
*   → 线圈电流在 ~3ms 内衰减到零 (比触点动作快)
*   → 触点是在接近零电流时断开 → 减少电弧

*** 4.3 继电器触点动作时间 ***
* 操作时间 (吸合): ≤ 10ms
* 释放时间: ≤ 5ms
* 触点弹跳: ~1ms (吸合时), ~0.5ms (释放时)
*
* 固件中 RELAY_SETTLE_MS = 12ms (10ms + 2ms 裕度)
* 这覆盖了操作时间 + 弹跳稳定

* ============================================================
* 5. 控制语句
* ============================================================
* .control
*   tran 10u 100m
*   plot i(L_coil)
*   plot v(N_COIL)
*   * 功耗: P_uln2003a = Vce × Ic
*   let P_uln = v(N_COIL,N_EMIT1) * i(V_12V)
*   plot P_uln
* .endc

.end
